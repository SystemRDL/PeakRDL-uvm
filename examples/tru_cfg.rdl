//-----------------------------------------------------------------------------
// User Defined Properties (UDP)
//-----------------------------------------------------------------------------
`include "defined_udps.rdl"

//-----------------------------------------------------------------------------
// Register block - Trigger Routing Unit
//-----------------------------------------------------------------------------
addrmap trigger_routing_unit {
  name = "Trigger Routing Unit";
  desc = "The trigger routing unit (TRU) provides simple sequence control of
  distributed modules without the penalties assocaiated with core intervention
  ";

  lsb0;
  littleendian;
  
  // Useful when we need to search the map by name
  map_name_p = "trigger_routing_unit_map";

  address_width_p = 32;
  base_address_p = 32'h1000_0000;

  default accesswidth = 32;
  default regwidth = 32;

  reg { 
    name = "Slave Select Register";
    desc = "The TRU slave select registers (TRU_SSRn) each provide
    slave selection and register locking.";

    regaccess_p = "RW";

    field { 
      name = "SSRn Lock";
      desc = "If the global lock is enabled (SPU_CTL_GLCK bit =1) and the TRU_
      SSRn.LOCK bit is enabled, the TRU_SSRn register is read only.";

      hw = r; 
      sw = rw; 
      fieldwidth = 1; 
    } lock[31:31] = 1'h0;

    field { 
      name = "Reserved1";
      desc = "Reserved bits";

      hw = na; 
      sw = rw; 
      fieldwidth = 23; 
    } reserved1[30:8] = 23'h0;

    field {
      name = "SSRn Slave Select";
      desc = "The TRU_SSRn register selects the trigger master ID to which the
      trigger slave responds. For example, when a TRU_SSRn register is set
      to respond to trigger master ID n, a trigger that is generated by
      trigger master ID n results in a trigger out to the slave.";

      hw = r;
      sw = rw;
      fieldwidth = 8;
    } ssr[7:0] = 8'h0; 

  } tru_ssrn @0x2000;

  reg { 
    name = "Master Trigger Register";
    desc = "The TRU master trigger register (TRU_MTR) permits trigger generation 
    through software by writing a trigger master ID value to one of the four fields
    in the TRU_MTR register. If the global lock is enabled SPU_CTL_GLCK bit =1) and 
    the TRU_GCTL.LOCK bit is set, the TRU_MTR register is read only.";

    regaccess_p = "RW";

    field {
      name = "Master Trigger Register 3";
      desc = "";

      hw = r;
      sw = rw;
      fieldwidth = 8;
    } mtr3[31:24] = 8'h0; 

    field {
      name = "Master Trigger Register 2";
      desc = "";

      hw = r;
      sw = rw;
      fieldwidth = 8;
    } mtr2[23:16] = 8'h0; 

    field {
      name = "Master Trigger Register 1";
      desc = "";

      hw = r;
      sw = rw;
      fieldwidth = 8;
    } mtr1[15:8] = 8'h0; 

    field {
      name = "Master Trigger Register 0";
      desc = "";

      hw = r;
      sw = rw;
      fieldwidth = 8;
    } mtr0[7:0] = 8'h0; 

  } tru_mtr @0x2004;

  reg { 
    name = "Error Address Register";
    desc = "The TRU error address register (TRU_ERRADDR) holds the address 
    from the memory mapped register access generating an access error of TRU registers.";

    regaccess_p = "RW";

    field { 
      name = "Reserved1";
      desc = "Reserved bits";

      hw = na; 
      sw = rw; 
      fieldwidth = 20; 
    } reserved1[31:12] = 20'h0;

    field { 
      name = "Error Address";
      desc = "The TRU_ERRADDR.ADDR holds the address from the memory
      mapped register access generating an access error of TRU registers.
      These errors occur on access to the TRU_SSRn or TRU_MTR registers
      when these registers are locked or on access to an invalid address.
      See the TRU_SSRn and TRU_MTR register descriptions for more
      information about locking. The TRU_ERRADDR register holds the
      address of the first error to occur. In the event of multiple errors
      occurring, the TRU_ERRADDR register contains the address of the first
      error. To re-enable the TRU_ERRADDR register for update, both status
      bits (TRU_STAT.LWERR and TRU_STAT.ADDRERR) in the TRU_STAT
      register must be cleared.";

      hw = r; 
      sw = rw; 
      fieldwidth = 12; 
    } addr[11:0] = 12'h0;

  } tru_erraddr @0x2010;

  reg { 
    name = "Status Information Register";
    desc = "The TRU status register (TRU_STAT) contains the status of TRU_MTR and 
    TRU_SSRn register writes and status of bus read/write errors.";

    regaccess_p = "RW";

    field { 
      name = "Reserved1";
      desc = "Reserved bits";

      hw = na; 
      sw = rw; 
      fieldwidth = 30; 
    } reserved1[31:2] = 30'h0;

    field { 
      name = "Address Error Status";
      desc = "The TRU_STAT.ADDRERR bit is set when an invalid address is
      provided for an MMR access while the TRU is selected. Writing a one
      to this bit clears the error indication. The TRU_ERRADDR register also
      is updated when an address error occurs during an MMR access
      while the TRU is selected.";

      // HW - W1S
      hw = w; hwset = true; 
      // SW - W1C
      sw = rw; onwrite = woclr;
      fieldwidth = 1; 
    } addrerr[1:1] = 1'h0;

    field { 
      name = "Lock Write Error Status";
      desc = "If TRU_STAT.LWERR is set, a lock write error has occurred. 
      Writing a one to this bit clears the error indication.";

      // HW - W1S
      hw = w; hwset = true; 
      // SW - W1C
      sw = rw; onwrite = woclr;
      fieldwidth = 1; 
    } lwerr[0:0] = 1'h0;

  } tru_stat @0x2014;

  reg { 
    name = "Global Control Register";
    desc = "The TRU global control register (TRU_GCTL) provides register locking, 
    TRU reset, and TRU enable.";

    regaccess_p = "RW";

    field {
      name = "GCTL Lock Bit";
      desc = "If the global lock is enabled (SPU_CTL_GLCK bit =1) and the TRU_
      GCTL.LOCK bit is enabled, the TRU_GCTL register is read only.";

      hw = r; 
      sw = rw; 
      fieldwidth = 1; 
    } lock[31:31] = 1'h0;
    
    field { 
      name = "Reserved1";
      desc = "Reserved bits";

      hw = na; 
      sw = rw; 
      fieldwidth = 28; 
    } reserved1[30:3] = 28'h0;

    field {
      name = "MTR Lock Bit";
      desc = "If the global lock is enabled (SPU_CTL_GLCK bit =1) and the TRU_
      GCTL.MTRL bit is enabled, the TRU_MTR register is read only.";

      hw = r; 
      sw = rw; 
      fieldwidth = 1; 
    } mtrl[2:2] = 1'h0;
    
    field {
      name = "Soft Reset";
      desc = "The TRU_GCTL.RESET bit is write-1-action and triggers a soft reset to
      all TRU registers.";

      hw = r; 
      sw = rw; 
      fieldwidth = 1; 
    } reset[1:1] = 1'h0;
    
    field {
      name = "Non-MMR Enable";
      desc = "The TRU_GCTL.EN bit is read/write and must be set for the TRU to
      propagate trigger events. All TRU register read/write operations
      continue to operate independent of the TRU_GCTL.EN bit.";

      hw = r; 
      sw = rw; 
      fieldwidth = 1; 
    } en[0:0] = 1'h0;
    
  } tru_gctl @0x2018;

  reg { 
    name = "Receive Data Register";
    desc = "Used for storing the received data";

    regaccess_p = "RO";

    field {
      name = "Receive Data";
      desc = "The Trigger block received data is stored in this field";

      hw = w; 
      sw = r; 
      fieldwidth = 32; 
    } rxdata[31:0] = 32'h0;

  } tru_rxdata @0x201c;



};
